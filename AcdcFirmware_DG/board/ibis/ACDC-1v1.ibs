[IBIS Ver]   4.2
[Comment Char] |_char
[File Name]   acdc-1v1.ibs
[File Rev]   1.0
[Date]   August 11, 2020
[Source]   Derived from cycloneIII_spice_model,rev 1.0, dated 11/02/07
   using HSPICE Y-2006.03
[Notes]   - The models are designated as "Correlated" and have been
   correlated against physical device operation.
   - This IBIS model is checked using IBISCHK v4.2.2
   There are no known errors and warnings reported.
   - There are no known limitations for this IBIS model release.
   - Contact point: Altera Corporation,
   http://www.altera.com/corporate/contact/con-index.html
   - This file is generated using Quartus II
   Version 18.1.0 Build 625 09/12/2018 SJ Standard Edition
   - Unused IOs which have been assigned as tri-stated inputs or
   as outputs driving any signal in Quartus II are represented
   by the NC.
   - Only general purpose and configuration I/O IBIS models are
   supported
   Revision History
   - v1.0
   - Initial Release of Cyclone IV IBIS models
   - v2.0
   - Added configuration pins IBIS models
   - C_comp values for different pin types
   When an IBIS model is assigned to different pin types in
   Cyclone III LS devices, the C_comp value will be different.
   Use the following C_comp values according to the pin types:
   Pin Type   C_comp
   Normal Column I/O   4.7pF
   Normal Row I/O   4.4pF
   Differential Row I/O   5.0pF
   *Note (1): These IBIS models are generated based on a
   pre-determined Quartus II default slew rate setting.
   For IBIS models with other slew rate settings,
   please contact Altera Corporation.
[Disclaimer]   Data is for modeling purposes only and is not guaranteed.
[Copyright]   Copyright (C) 2018  Intel Corporation. All rights reserved.
[Component]   EP4CGX110DF27C7_acdc-1v1
[Manufacturer] Altera Corporation
[Package]
| RLC values are for 672 FBGA package
| variable  typ   min   max
R_pkg   304m   135m   432m
L_pkg   5.67nH   2.42nH   8.42nH
C_pkg   0.50pF   0.30pF   0.64pF
[Pin]  signal_name   model_name   R_pin   L_pin   C_pin
A10   USB_bus.FD[1]   cmos33_cio_d2p
A11   unusedOutput.FPGA_CLKOUT   cmos33_cio_d2p
A12   USB_bus.FD[2]   cmos33_cio_d2p
A13   USB_bus.FD[3]   cmos33_cio_d2p
A14   unusedInput.refClockIn[4]   ttl25_cin_p
A15   PSEC4_out[0].readClock   ttl25_cio_r50
A16   PSEC4_in[0].data[8]   ttl25_cin_p
A17   PSEC4_in[0].data[7]   ttl25_cin_p
A18   PSEC4_in[0].trig[2]   ttl25_cin_p
A19   PSEC4_in[0].trig[0]   ttl25_cin_p
A2   jcpll_ctrl.testMode   cmos33_cio_d2
A20   PSEC4_in[0].data[0]   ttl25_cin_p
A21   PSEC4_out[0].TokDecode[0]   ttl25_cio_r50
A22   PSEC4_out[0].channel[1]   ttl25_cio_r50
A23   PSEC4_in[0].ringOsc_mon   ttl25_cin_p
A24   PSEC4_out[0].ringOsc_enable   ttl25_cio_r50
A25   unusedOutput.trigSign   ttl25_cio_r50p
A3   jcpll_ctrl.spi_latchEnable   cmos33_cio_d2
A4   unusedInput.Jctrl_miso   cmos33_cin_p
A5   jcpll_ctrl.spi_mosi   cmos33_cio_d2
A6   USB_bus.PA[0]   cmos33_cio_d2p
A7   USB_bus.PA[4]   cmos33_cio_d2p
A8   USB_bus.PA[5]   cmos33_cio_d2p
A9   USB_bus.FD[0]   cmos33_cio_d2p
AA10   VCCIO3   POWER
AA11   VCCIO3   POWER
AA12   VCCIO3   POWER
AA13   VCCIO3   POWER
AA14   VCCIO3   POWER
AA15   PSEC4_in[4].data[1]   ttl25_cin_p
AA16   VCCIO4   POWER
AA17   unusedOutput.GPIO_1V2[16]   ttl25_cio_r50p
AA18   VCCIO4   POWER
AA19   VCCIO4   POWER
AA20   PSEC4_out[3].channel[2]   ttl25_cio_r50
AA21   unusedOutput.CLKOUT_1V2[2]   ttl25_cio_r50p
AA22   unusedOutput.reservedOutput[6]   ttl25_cio_r50p
AA23   PSEC4_in[3].trig[3]   ttl25_rdin_p
AA24   PSEC4_in[3].trig[5]   ttl25_rdin_p
AA25   PSEC4_in[3].data[8]   ttl25_rdin_p
AA26   PSEC4_in[3].data[9]   ttl25_rdin_p
AA3   VCCL_GXB   POWER
AA4   VCCL_GXB   POWER
AA7   calEnable[4]   ttl25_cio_r50
AA8   calEnable[8]   ttl25_cio_r50
AA9   unusedOutput.GPIO_2V5[14]   ttl25_cio_r50p
AB1   GND   GND
AB10   GND   GND
AB11   ledOut[0]   ttl25_cio_r50
AB12   calEnable[0]   ttl25_cio_r50
AB13   GND   GND
AB14   unusedOutput.reservedOutput[3]   ttl25_cio_r50p
AB15   PSEC4_in[4].data[0]   ttl25_cin_p
AB16   GND   GND
AB17   VCCIO4   POWER
AB18   unusedOutput.reservedOutput[4]   ttl25_cio_r50p
AB19   GND   GND
AB2   GND   GND
AB20   PSEC4_in[3].ringOsc_mon   ttl25_cin_p
AB21   unusedOutput.CLKOUT_1V2[3]   ttl25_cio_r50p
AB22   GND   GND
AB23   PSEC4_in[3].trig[1]   ttl25_rdin_p
AB24   PSEC4_in[3].trig[4]   ttl25_rdin_p
AB25   GND   GND
AB26   PSEC4_in[3].data[6]   ttl25_rdin_p
AB5   unusedOutput.CLKOUT_2V5[0]   ttl25_cio_r50p
AB7   unusedOutput.initDone   ttl25_cio_r50p
AB8   calEnable[9]   ttl25_cio_r50
AB9   calEnable[5]   ttl25_cio_r50
AC10   ledOut[5]   ttl25_cio_r50
AC11   calEnable[12]   ttl25_cio_r50
AC12   calEnable[2]   ttl25_cio_r50
AC14   PSEC4_out[4].TokDecode[0]   ttl25_cio_r50
AC15   PSEC4_out[4].extTrig   ttl25_cio_r50
AC16   PSEC4_in[4].data[4]   ttl25_cin_p
AC17   PSEC4_in[4].trig[2]   ttl25_cin_p
AC18   PSEC4_in[4].data[7]   ttl25_cin_p
AC19   PSEC4_in[4].data[11]   ttl25_cin_p
AC2   GND   GND
AC20   unusedOutput.reservedOutput[5]   ttl25_cio_r50p
AC21   PSEC4_out[4].TokIn[1]   ttl25_cio_r50
AC22   PSEC4_out[3].TokDecode[2]   ttl25_cio_r50
AC23   PSEC4_in[3].trig[2]   ttl25_rdin_p
AC24   PSEC4_in[3].data[4]   ttl25_rdin_p
AC25   PSEC4_in[3].data[3]   ttl25_rdin_p
AC26   PSEC4_in[3].data[5]   ttl25_rdin_p
AC3   VCCA_GXB   POWER
AC4   unusedOutput.CLKOUT_2V5[2]   ttl25_cio_r50p
AC5   unusedOutput.CLKOUT_2V5[1]   ttl25_cio_r50p
AC6   calEnable[11]   ttl25_cio_r50
AC8   calEnable[10]   ttl25_cio_r50
AC9   unusedOutput.GPIO_2V5[15]   ttl25_cio_r50p
AD1   GND   GND
AD10   ledOut[2]   ttl25_cio_r50
AD12   ledOut[7]   ttl25_cio_r50
AD14   PSEC4_out[4].TokDecode[1]   ttl25_cio_r50
AD15   PSEC4_out[4].ADCclear   ttl25_cio_r50
AD16   PSEC4_in[4].data[3]   ttl25_cin_p
AD17   PSEC4_in[4].trig[1]   ttl25_cin_p
AD18   PSEC4_in[4].trig[5]   ttl25_cin_p
AD19   PSEC4_in[4].data[10]   ttl25_cin_p
AD2   VCCL_GXB   POWER
AD20   PSEC4_out[4].DLLreset_n   ttl25_cio_r50
AD21   PSEC4_out[4].readClock   ttl25_cio_r50
AD22   PSEC4_out[3].TokIn[0]   ttl25_cio_r50
AD23   PSEC4_out[3].ADClatch   ttl25_cio_r50
AD24   PSEC4_out[3].ADCclear   ttl25_cio_r50
AD25   PSEC4_in[3].data[1]   ttl25_rdin_p
AD26   PSEC4_in[3].trig[0]   ttl25_rdin_p
AD3   unusedOutput.CLKOUT_2V5[4]   ttl25_cio_r50p
AD4   unusedOutput.CLKOUT_2V5[3]   ttl25_cio_r50p
AD9   unusedOutput.GPIO_2V5[16]   ttl25_cio_r50p
AE1   LVDS_out[0]   lvds25_co_e3r
AE11   calEnable[13]   ttl25_cio_r50
AE12   GND   GND
AE14   PSEC4_out[4].TokDecode[2]   ttl25_cio_r50
AE15   PSEC4_out[4].ADClatch   ttl25_cio_r50
AE16   GND   GND
AE17   PSEC4_in[4].data[5]   ttl25_cin_p
AE18   PSEC4_in[4].trig[4]   ttl25_cin_p
AE19   PSEC4_in[4].data[9]   ttl25_cin_p
AE2   LVDS_out[0](n)   lvds25_co_e3r
AE20   GND   GND
AE21   PSEC4_out[4].trigClear   ttl25_cio_r50
AE22   PSEC4_out[3].channel[0]   ttl25_cio_r50
AE23   PSEC4_out[3].TokDecode[0]   ttl25_cio_r50
AE24   GND   GND
AE25   PSEC4_in[3].data[0]   ttl25_rdin_p
AE26   PSEC4_in[3].data[2]   ttl25_rdin_p
AE3   unusedOutput.CLKOUT_2V5[5]   ttl25_cio_r50p
AE4   GND   GND
AE5   LVDS_in[0]   lvds25_cin
AE6   LVDS_in[0](n)   lvds25_cin
AE7   calEnable[7]   ttl25_cio_r50
AE8   GND   GND
AE9   LVDS_in[1]   lvds25_cin
AF11   LVDS_in[2]   lvds25_cin
AF12   LVDS_in[2](n)   lvds25_cin
AF13   PSEC4_in[4].DLL_clock   ttl25_cin_p
AF15   PSEC4_out[4].TokIn[0]   ttl25_cio_r50
AF16   PSEC4_in[4].data[2]   ttl25_cin_p
AF17   PSEC4_in[4].trig[0]   ttl25_cin_p
AF18   PSEC4_in[4].trig[3]   ttl25_cin_p
AF19   PSEC4_in[4].data[8]   ttl25_cin_p
AF2   LVDS_out[1]   lvds25_co_e3r
AF20   PSEC4_in[4].overflow   ttl25_cin_p
AF21   PSEC4_out[4].rampStart   ttl25_cio_r50
AF22   PSEC4_out[3].channel[1]   ttl25_cio_r50
AF23   PSEC4_out[3].TokDecode[1]   ttl25_cio_r50
AF24   PSEC4_out[3].ringOsc_enable   ttl25_cio_r50
AF25   PSEC4_out[3].extTrig   ttl25_cio_r50
AF3   LVDS_out[1](n)   lvds25_co_e3r
AF4   LVDS_out[2]   lvds25_co_e3r
AF5   LVDS_out[2](n)   lvds25_co_e3r
AF6   calEnable[3]   ttl25_cio_r50
AF7   LVDS_out[3]   lvds25_co_e3r
AF8   LVDS_out[3](n)   lvds25_co_e3r
AF9   LVDS_in[1](n)   lvds25_cin
B1   jcpll_ctrl.powerDown   cmos33_cio_d2
B10   unusedOutput.GPIO_3V3[7]   cmos33_cio_d2p
B11   USB_bus.FD[4]   cmos33_cio_d2p
B12   GND   GND
B13   USB_in.CTL[2]   cmos33_cin_p
B14   PSEC4_in[0].DLL_clock   ttl25_cin_p
B15   PSEC4_out[0].rampStart   ttl25_cio_r50
B16   GND   GND
B17   PSEC4_in[0].data[9]   ttl25_cin_p
B18   PSEC4_in[0].trig[3]   ttl25_cin_p
B19   PSEC4_in[0].data[3]   ttl25_cin_p
B2   jcpll_lock   cmos33_cin_p
B20   GND   GND
B21   PSEC4_out[0].ADClatch   ttl25_cio_r50
B22   PSEC4_out[0].channel[0]   ttl25_cio_r50
B23   PSEC4_out[0].channel[2]   ttl25_cio_r50
B24   GND   GND
B25   PSEC4_out[1].TokIn[1]   ttl25_rdio_r50
B26   PSEC4_out[1].trigClear   ttl25_rdio_r50
B3   GND   GND
B4   DAC[2].serialClock   cmos33_cio_d2
B5   DAC[2].serialData   cmos33_cio_d2
B6   USB_bus.PA[1]   cmos33_cio_d2p
B7   USB_bus.PA[3]   cmos33_cio_d2p
B8   GND   GND
B9   USB_bus.PA[6]   cmos33_cio_d2p
C1   DAC[1].clear   cmos33_cio_d2
C10   USB_bus.PA[7]   cmos33_cio_d2p
C11   unusedOutput.GPIO_3V3[9]   cmos33_cio_d2p
C12   USB_bus.FD[6]   cmos33_cio_d2p
C13   USB_in.CTL[1]   cmos33_cin_p
C14   PSEC4_out[0].DLLreset_n   ttl25_cio_r50
C15   PSEC4_out[0].trigClear   ttl25_cio_r50
C16   PSEC4_in[0].overflow   ttl25_cin_p
C17   PSEC4_in[0].data[10]   ttl25_cin_p
C18   PSEC4_in[0].trig[4]   ttl25_cin_p
C19   PSEC4_in[0].data[4]   ttl25_cin_p
C2   jcpll_ctrl.refSelect   cmos33_cio_d2
C20   PSEC4_in[0].data[1]   ttl25_cin_p
C21   PSEC4_out[0].extTrig   ttl25_cio_r50
C22   PSEC4_out[0].TokDecode[1]   ttl25_cio_r50
C23   PSEC4_out[0].TokIn[0]   ttl25_cio_r50
C24   PSEC4_out[1].rampStart   ttl25_rdio_r50
C25   PSEC4_out[1].DLLreset_n   ttl25_rdio_r50
C26   PSEC4_out[1].readClock   ttl25_rdio_r50
C3   unusedInput.DAC1_miso   cmos33_cin_p
C4   DAC[1].load   cmos33_cio_d2
C5   jcpll_ctrl.pllSync   cmos33_cio_d2
C7   USB_bus.PA[2]   cmos33_cio_d2p
C8   DAC[0].load   cmos33_cio_d2
C9   DAC[2].load   cmos33_cio_d2
D1   unusedInput.Jctrl_aux_out   cmos33_cin_p
D10   USB_bus.FD[5]   cmos33_cio_d2p
D11   unusedOutput.reservedOutput[1]   cmos33_cio_d2p
D12   unusedOutput.GPIO_3V3[12]   cmos33_cio_d2p
D13   USB_bus.FD[8]   cmos33_cio_d2p
D14   unusedOutput.reservedOutput[2]   cmos33_cio_d2p
D15   PSEC4_out[0].TokIn[1]   ttl25_cio_r50
D16   unusedOutput.reservedOutput[16]   ttl25_cio_r50p
D17   PSEC4_in[0].data[11]   ttl25_cin_p
D18   PSEC4_in[0].data[6]   ttl25_cin_p
D19   PSEC4_in[0].data[5]   ttl25_cin_p
D2   jcpll_ctrl.spi_clock   cmos33_cio_d2
D20   PSEC4_in[0].data[2]   ttl25_cin_p
D21   PSEC4_out[0].ADCclear   ttl25_cio_r50
D22   PSEC4_out[0].TokDecode[2]   ttl25_cio_r50
D23   unusedOutput.reservedOutput[14]   ttl25_cio_r50p
D24   unusedOutput.freqSel   ttl25_rdio_r50p
D25   PSEC4_in[1].overflow   ttl25_rdin_p
D26   PSEC4_in[1].data[11]   ttl25_rdin_p
D3   DAC[1].serialData   cmos33_cio_d2
D4   unusedOutput.MCLK   cmos33_cio_d2p
D7   SMA_trigIn   cmos33_cin_p
D8   DAC[0].serialData   cmos33_cio_d2
E1   DAC[0].clear   cmos33_cio_d2
E10   VCCIO8   POWER
E11   unusedOutput.GPIO_3V3[10]   cmos33_cio_d2p
E12   USB_bus.FD[7]   cmos33_cio_d2p
E13   USB_in.CTL[0]   cmos33_cin_p
E14   USB_bus.FD[9]   cmos33_cio_d2p
E15   unusedOutput.GPIO_1V2[1]   ttl25_cio_r50p
E16   unusedOutput.GPIO_1V2[0]   ttl25_cio_r50p
E17   unusedOutput.reservedOutput[17]   ttl25_cio_r50p
E18   PSEC4_in[0].trig[5]   ttl25_cin_p
E19   PSEC4_in[0].trig[1]   ttl25_cin_p
E2   DAC[1].serialClock   cmos33_cio_d2
E20   unusedOutput.reservedOutput[18]   ttl25_cio_r50p
E21   unusedOutput.CLKOUT_1V2[1]   ttl25_cio_r50p
E22   unusedOutput.CLKOUT_1V2[0]   ttl25_cio_r50p
E23   unusedOutput.reservedOutput[15]   ttl25_cio_r50p
E24   PSEC4_in[1].data[10]   ttl25_rdin_p
E25   PSEC4_in[1].data[9]   ttl25_rdin_p
E26   PSEC4_in[1].data[8]   ttl25_rdin_p
E3   GND   GND
E4   GND   GND
E7   DAC[0].serialClock   cmos33_cio_d2
E8   DAC[2].clear   cmos33_cio_d2
E9   unusedOutput.reservedOutput[0]   cmos33_cio_d2p
F1   GND   GND
F10   GND   GND
F11   VCCIO8   POWER
F12   GND   GND
F13   VCCIO8   POWER
F14   VCCIO8   POWER
F15   unusedOutput.GPIO_1V2[2]   ttl25_cio_r50p
F16   VCCIO7   POWER
F17   GND   GND
F18   VCCIO7   POWER
F19   GND   GND
F2   GND   GND
F20   VCCIO7   POWER
F21   unusedOutput.reservedOutput[20]   ttl25_rdio_r50p
F22   GND   GND
F23   PSEC4_in[1].trig[5]   ttl25_rdin_p
F24   PSEC4_in[1].trig[4]   ttl25_rdin_p
F25   GND   GND
F26   PSEC4_in[1].trig[3]   ttl25_rdin_p
F5   altera_reserved_tms   ttl33_rin
F7   GND   GND
F8   unusedInput.DAC0_miso   cmos33_cin_p
F9   VCCIO8   POWER
G10   unusedOutput.GPIO_3V3[8]   cmos33_cio_d2p
G11   USB_bus.FD[12]   cmos33_cio_d2p
G12   VCCIO8   POWER
G13   GND   GND
G14   unusedOutput.GPIO_1V2[3]   ttl25_cio_r50p
G15   unusedOutput.GPIO_1V2[4]   ttl25_cio_r50p
G16   VCCIO7   POWER
G17   unusedOutput.GPIO_1V2[5]   ttl25_cio_r50p
G18   VCCIO7   POWER
G19   VCCIO7   POWER
G21   VCCD_PLL   POWER
G22   PSEC4_in[1].trig[2]   ttl25_rdin_p
G23   unusedOutput.reservedOutput[22]   ttl25_rio_r50p
G24   PSEC4_in[1].data[7]   ttl25_rdin_p
G25   PSEC4_in[1].data[6]   ttl25_rdin_p
G26   PSEC4_in[1].data[5]   ttl25_rdin_p
G3   GND   GND
G4   GND   GND
G5   VCCL_GXB   POWER
G6   altera_reserved_tdi   ttl33_rin
G7   VCCIO9   POWER
G8   altera_reserved_tck   ttl33_rin
G9   USB_bus.FD[10]   cmos33_cio_d2p
H1   GND   GND
H10   USB_bus.FD[11]   cmos33_cio_d2p
H11   unusedOutput.GPIO_3V3[11]   cmos33_cio_d2p
H12   USB_bus.FD[13]   cmos33_cio_d2p
H13   USB_in.WAKEUP   cmos33_cin_p
H14   unusedOutput.GPIO_1V2[10]   ttl25_cio_r50p
H15   unusedOutput.GPIO_1V2[9]   ttl25_cio_r50p
H16   unusedOutput.GPIO_1V2[8]   ttl25_cio_r50p
H17   unusedOutput.GPIO_1V2[7]   ttl25_cio_r50p
H18   unusedOutput.GPIO_1V2[6]   ttl25_cio_r50p
H19   GND   GND
H2   GND   GND
H20   VCCA   POWER
H21   VCCIO6   POWER
H22   PSEC4_in[1].data[4]   ttl25_rdin_p
H23   PSEC4_in[1].trig[1]   ttl25_rdin_p
H24   PSEC4_in[1].trig[0]   ttl25_rdin_p
H25   PSEC4_in[1].data[3]   ttl25_rdin_p
H26   PSEC4_in[1].data[2]   ttl25_rdin_p
H5   VCCL_GXB   POWER
H6   VCCA   POWER
H8   altera_reserved_tdo   2p5_o_tdo
H9   unusedOutput.GPIO_3V3[6]   cmos33_cio_d2p
J10   VCCINT   POWER
J11   USB_out.RDY[1]   cmos33_cio_d2
J12   USB_out.RDY[0]   cmos33_cio_d2
J13   USB_bus.FD[14]   cmos33_cio_d2p
J14   clockIn.usb_IFCLK   cmos33_cin_p
J15   unusedOutput.GPIO_1V2[11]   ttl25_cio_r50p
J16   unusedOutput.GPIO_1V2[12]   ttl25_cio_r50p
J17   unusedOutput.GPIO_1V2[13]   ttl25_cio_r50p
J18   unusedOutput.GPIO_1V2[14]   ttl25_cio_r50p
J19   unusedOutput.GPIO_1V2[15]   ttl25_cio_r50p
J20   unusedOutput.reservedOutput[19]   ttl25_rdio_r50p
J21   VCCIO6   POWER
J22   GND   GND
J23   PSEC4_in[1].data[1]   ttl25_rdin_p
J24   unusedOutput.reservedOutput[21]   ttl25_rio_r50p
J25   PSEC4_in[1].data[0]   ttl25_rdin_p
J26   PSEC4_out[1].extTrig   ttl25_rdio_r50
J3   GND   GND
J4   GND   GND
J5   VCCH_GXB   POWER
J6   VCCD_PLL   POWER
J8   GND   GND
J9   VCC_CLKIN8B   POWER
K1   GND   GND
K11   GND   GND
K12   USB_bus.FD[15]   cmos33_cio_d2p
K13   USB_in.CLKOUT   cmos33_cin_p
K14   VCC_CLKIN8A   POWER
K15   GND   GND
K16   VCCINT   POWER
K17   GND   GND
K18   VCCINT   POWER
K19   PSEC4_out[1].TokDecode[2]   ttl25_rdio_r50
K2   GND   GND
K20   PSEC4_out[1].TokDecode[1]   ttl25_rdio_r50
K21   PSEC4_out[1].TokDecode[0]   ttl25_rdio_r50
K22   PSEC4_out[1].TokIn[0]   ttl25_rdio_r50
K23   PSEC4_out[1].ringOsc_enable   ttl25_rdio_r50
K24   PSEC4_out[1].ADClatch   ttl25_rdio_r50
K25   GND   GND
K26   PSEC4_out[1].ADCclear   ttl25_rdio_r50
K5   VCCA_GXB   POWER
K7   VCCA   POWER
K8   VCCINT   POWER
L11   VCCINT   POWER
L12   GND   GND
L13   VCCINT   POWER
L16   GND   GND
L17   VCCINT   POWER
L18   GND   GND
L19   PSEC4_out[1].channel[2]   ttl25_rdio_r50
L20   VCCIO6   POWER
L21   PSEC4_out[1].channel[1]   ttl25_rdio_r50
L22   PSEC4_out[1].channel[0]   ttl25_rdio_r50
L23   PSEC4_in[1].ringOsc_mon   ttl25_rdin_p
L24   PSEC4_out[2].TokIn[1]   ttl25_rdio_r50
L25   PSEC4_out[2].trigClear   ttl25_rdio_r50
L26   PSEC4_out[2].readClock   ttl25_rdio_r50
L3   GND   GND
L4   GND   GND
L5   VCCL_GXB   POWER
L6   VCCD_PLL   POWER
L7   VCCINT   POWER
L8   GND   GND
M1   GND   GND
M10   VCCINT   POWER
M11   GND   GND
M12   VCCINT   POWER
M13   GND   GND
M14   VCCINT   POWER
M15   GND   GND
M16   VCCINT   POWER
M17   GND   GND
M18   VCCINT   POWER
M19   PSEC4_out[2].rampStart   ttl25_rdio_r50
M2   GND   GND
M20   VCCIO6   POWER
M21   GND   GND
M22   PSEC4_out[2].DLLreset_n   ttl25_rdio_r50
M23   unusedOutput.reservedOutput[23]   ttl25_rio_r50p
M24   PSEC4_in[2].overflow   ttl25_rdin_p
M25   PSEC4_in[2].data[11]   ttl25_rdin_p
M26   PSEC4_in[2].data[10]   ttl25_rdin_p
M5   VCCH_GXB   POWER
M6   VCCD_PLL   POWER
M7   GND   GND
M8   VCCINT   POWER
M9   GND   GND
N10   GND   GND
N11   VCCINT   POWER
N12   GND   GND
N13   VCCINT   POWER
N14   GND   GND
N15   VCCINT   POWER
N16   GND   GND
N17   VCCINT   POWER
N18   GND   GND
N19   PSEC4_in[2].trig[5]   ttl25_rdin_p
N20   PSEC4_in[2].data[6]   ttl25_rdin_p
N21   VCCIO6   POWER
N22   PSEC4_in[2].data[7]   ttl25_rdin_p
N23   PSEC4_in[2].data[8]   ttl25_rdin_p
N24   PSEC4_in[2].data[9]   ttl25_rdin_p
N25   PSEC4_in[2].DLL_clock   ttl25_rdin_p
N26   PSEC4_in[1].DLL_clock   ttl25_rdin_p
N3   GND   GND
N4   GND   GND
N5   VCCA_GXB   POWER
N7   VCCA   POWER
N8   GND   GND
N9   VCCINT   POWER
P1   GND   GND
P10   VCCINT   POWER
P11   GND   GND
P12   VCCINT   POWER
P13   GND   GND
P14   VCCINT   POWER
P15   GND   GND
P16   VCCINT   POWER
P17   GND   GND
P18   VCCINT   POWER
P19   PSEC4_in[2].trig[0]   ttl25_rdin_p
P2   GND   GND
P20   PSEC4_in[2].trig[3]   ttl25_rdin_p
P21   VCCIO5   POWER
P22   GND   GND
P23   PSEC4_in[2].trig[4]   ttl25_rdin_p
P24   unusedOutput.reservedOutput[9]   ttl25_rdio_r50p
P25   GND   GND
P26   unusedInput.reservedInput   ttl25_rdin_p
P5   VCCL_GXB   POWER
P7   VCCA   POWER
P8   VCCINT   POWER
P9   GND   GND
R10   GND   GND
R11   VCCINT   POWER
R12   GND   GND
R13   VCCINT   POWER
R14   GND   GND
R15   VCCINT   POWER
R16   GND   GND
R17   VCCINT   POWER
R18   GND   GND
R19   PSEC4_in[2].trig[1]   ttl25_rdin_p
R20   PSEC4_in[2].data[3]   ttl25_rdin_p
R21   VCCIO5   POWER
R22   PSEC4_in[2].data[4]   ttl25_rdin_p
R23   PSEC4_in[2].trig[2]   ttl25_rdin_p
R24   unusedOutput.reservedOutput[11]   ttl25_rio_r50p
R25   PSEC4_in[2].data[5]   ttl25_rdin_p
R26   PSEC4_in[3].DLL_clock   ttl25_rdin_p
R3   GND   GND
R4   GND   GND
R5   VCCH_GXB   POWER
R6   VCCD_PLL   POWER
R7   VCCINT   POWER
R8   GND   GND
R9   VCCINT   POWER
T1   GND   GND
T11   GND   GND
T12   VCCINT   POWER
T13   GND   GND
T16   VCCINT   POWER
T17   GND   GND
T18   VCCINT   POWER
T19   PSEC4_out[2].TokDecode[1]   ttl25_rdio_r50
T2   GND   GND
T20   VCCIO5   POWER
T21   PSEC4_out[2].ADClatch   ttl25_rdio_r50
T22   PSEC4_out[2].extTrig   ttl25_rdio_r50
T23   PSEC4_out[2].ADCclear   ttl25_rdio_r50
T24   PSEC4_in[2].data[0]   ttl25_rdin_p
T25   PSEC4_in[2].data[2]   ttl25_rdin_p
T26   PSEC4_in[2].data[1]   ttl25_rdin_p
T5   VCCA_GXB   POWER
T6   VCCD_PLL   POWER
T7   GND   GND
T8   VCCINT   POWER
U11   VCCINT   POWER
U12   calEnable[14]   ttl25_cio_r50
U13   VCCINT   POWER
U14   VCC_CLKIN3A   POWER
U15   VCCINT   POWER
U16   unusedOutput.GPIO_1V2[21]   ttl25_cio_r50p
U17   VCCINT   POWER
U18   unusedOutput.GPIO_1V2[18]   ttl25_cio_r50p
U19   PSEC4_out[2].TokDecode[0]   ttl25_rdio_r50
U20   VCCIO5   POWER
U21   GND   GND
U22   PSEC4_out[2].TokDecode[2]   ttl25_rdio_r50
U23   PSEC4_out[2].TokIn[0]   ttl25_rdio_r50
U24   unusedOutput.reservedOutput[12]   ttl25_rio_r50p
U25   PSEC4_out[2].channel[1]   ttl25_rdio_r50
U26   PSEC4_out[2].channel[0]   ttl25_rdio_r50
U3   GND   GND
U4   GND   GND
U5   VCCL_GXB   POWER
U7   VCCA   POWER
U8   GND   GND
V1   GND   GND
V10   VCCINT   POWER
V12   ledOut[1]   ttl25_cio_r50
V13   ledOut[4]   ttl25_cio_r50
V14   calEnable[1]   ttl25_cio_r50
V16   PSEC4_out[4].ringOsc_enable   ttl25_cio_r50
V17   unusedOutput.GPIO_1V2[20]   ttl25_cio_r50p
V18   unusedOutput.GPIO_1V2[19]   ttl25_cio_r50p
V19   unusedOutput.GPIO_1V2[17]   ttl25_cio_r50p
V2   GND   GND
V20   VCCIO5   POWER
V21   unusedOutput.reservedOutput[10]   ttl25_rdio_r50p
V22   PSEC4_out[2].ringOsc_enable   ttl25_rdio_r50
V23   PSEC4_out[3].TokIn[1]   ttl25_rdio_r50
V24   PSEC4_in[2].ringOsc_mon   ttl25_rdin_p
V25   GND   GND
V26   PSEC4_out[2].channel[2]   ttl25_rdio_r50
V5   VCCH_GXB   POWER
V6   VCCD_PLL   POWER
V8   VCCINT   POWER
V9   VCC_CLKIN3B   POWER
W10   unusedOutput.GPIO_2V5[17]   ttl25_cio_r50p
W11   ledOut[6]   ttl25_cio_r50
W16   PSEC4_in[4].ringOsc_mon   ttl25_cin_p
W17   PSEC4_out[4].channel[0]   ttl25_cio_r50
W18   PSEC4_out[4].channel[1]   ttl25_cio_r50
W19   PSEC4_out[4].channel[2]   ttl25_cio_r50
W21   VCCA   POWER
W22   PSEC4_in[3].overflow   ttl25_rdin_p
W23   unusedOutput.reservedOutput[13]   ttl25_rio_r50p
W24   PSEC4_out[3].rampStart   ttl25_rdio_r50
W25   PSEC4_out[3].trigClear   ttl25_rdio_r50
W26   PSEC4_out[3].readClock   ttl25_rdio_r50
W3   GND   GND
W4   GND   GND
W5   VCCA_GXB   POWER
W6   VCCA   POWER
W8   VCCIO3   POWER
W9   unusedOutput.GPIO_2V5[12]   ttl25_cio_r50p
Y1   GND   GND
Y10   ledOut[8]   ttl25_cio_r50
Y11   ledOut[3]   ttl25_cio_r50
Y12   calEnable[6]   ttl25_cio_r50
Y13   unusedOutput.GPIO_2V5[13]   ttl25_cio_r50p
Y15   VCCIO4   POWER
Y16   GND   GND
Y17   PSEC4_in[4].data[6]   ttl25_cin_p
Y18   GND   GND
Y19   VCCIO4   POWER
Y2   GND   GND
Y20   VCCD_PLL   POWER
Y21   unusedOutput.reservedOutput[7]   ttl25_cio_r50p
Y22   unusedOutput.reservedOutput[8]   ttl25_rio_r50p
Y23   PSEC4_in[3].data[7]   ttl25_rin_p
Y24   PSEC4_in[3].data[10]   ttl25_rdin_p
Y25   PSEC4_in[3].data[11]   ttl25_rdin_p
Y26   PSEC4_out[3].DLLreset_n   ttl25_rdio_r50
Y5   VCCL_GXB   POWER
Y8   GND   GND
[Diff Pin]  inv_pin  vdiff  tdelay_typ  tdelay_min  tdelay_max
AE5   AE6   0.1   NA   NA   NA
AE9   AF9   0.1   NA   NA   NA
AF11   AF12   0.1   NA   NA   NA
| Models and submodels in the file (15): 2p5_o_tdo (Output), cmos33_cin_p (Input), cmos33_cio_d2 (I/O), cmos33_cio_d2p (I/O), lvds25_cin (Input), lvds25_co_e3r (Output), ttl25_cin_p (Input), ttl25_cio_r50 (I/O), ttl25_cio_r50p (I/O), ttl25_rdin_p (Input), ttl25_rdio_r50 (I/O), ttl25_rdio_r50p (I/O), ttl25_rin_p (Input), ttl25_rio_r50p (I/O), ttl33_rin (Input)
